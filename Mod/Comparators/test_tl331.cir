* TL331 Comparator Testbench - Transient Analysis
* VCC=5V, IN-=2.5V (ref), IN+=sine(2.5V, 3Vpk, 10kHz)
* Output with 10k pull-up to VCC

.INCLUDE /home/serg/Pulsar/Mod/Comparators/TL331.lib

VCC 5 0 DC 5
VREF 1 0 DC 2.5
VSIG 3 0 SIN(2.5 3 10k 0 0 0)

* TL331 comparator
XU1 1 0 3 4 5 TL331

* Pull-up resistor
RPU 4 5 10k

* Operating point for initial conditions
.IC V(4)=5

.TRAN 0.1u 500u UIC

.PRINT TRAN V(4) V(3) V(1)

.END
