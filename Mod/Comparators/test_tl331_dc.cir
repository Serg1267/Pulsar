* TL331 DC Sweep Test
.SUBCKT TL331 1 2 3 4 5
RINP 3 2 40MEG
RINN 1 2 40MEG
EERR 10 2 VOL='(V(3,2) - V(1,2) - 0.002)'
RERR 10 2 1G
EGAIN 20 2 VOL='V(10,2) * 200k'
RG 20 21 10k
CG 21 2 130p IC=0
SOUT 4 2 21 2 SWITCH_OUT
.MODEL SWITCH_OUT SW(VT=0 VH=0.01 RON=37.5 ROFF=10MEG)
DCLH 4 5 DID
DCLL 2 4 DID
RB 21 31 1k
QNPN 31 2 2 NPN_OUT
.MODEL NPN_OUT NPN (IS=1E-15 BF=100 NF=1 VAF=50 RB=50 RC=10 CJE=500f CJC=200f TF=1n TR=50n)
.MODEL DID D (IS=1e-14 N=1)
ICC_SRC 5 2 DC 0.4m
.ENDS TL331
VCC 5 0 DC 5
VREF 1 0 DC 2.5
VSIG 3 0 DC 0
XU1 1 0 3 4 5 TL331
RPU 4 5 10k
.DC VSIG 0 5 0.01
.PRINT DC V(4) V(3) V(1)
.END
