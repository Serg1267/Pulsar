* ==================================================================
* test
* ==================================================================
*
* Дата создания: 2026-06-04 21:17
*
* ==================================================================

* ------------------------------------------------------------------
* КОМПОНЕНТЫ СХЕМЫ
* ------------------------------------------------------------------
*
* Формат: <имя> <узел+> <узел-> <значение>
*
* Источники напряжения: Vxxx n+ n- <тип> <параметры>
* Резисторы:          Rxxx n+ n- <сопротивление>
* Конденсаторы:       Cxxx n+ n- <ёмкость>
* Индуктивности:      Lxxx n+ n- <индуктивность>
* Диоды:              Dxxx anode cathode <модель>
* Транзисторы:        Qxxx collector base emitter <модель>
*

* --- Источники ---
V1 out 0 sin 0 5 50

* --- Пассивные компоненты ---
R1 0 out 1k

* ------------------------------------------------------------------
* МОДЕЛИ КОМПОНЕНТОВ
* ------------------------------------------------------------------
*
* Формат: .MODEL <имя> <тип> (<параметры>)
*
* Типы моделей:
*   D   — диод
*   NPN — биполярный NPN-транзистор
*   PNP — биполярный PNP-транзистор
*   NMOS/PMOS — полевые транзисторы
*

* Примеры (закомментируйте или замените своими):
* .MODEL MyDiode D (IS=2.52n RS=.568 N=1.752)
* .MODEL MyTransistor NPN (BF=255.9 VAF=74.03)

* ------------------------------------------------------------------
* ДИРЕКТИВЫ АНАЛИЗА
* ------------------------------------------------------------------
*
* Типы анализов:
*   .TRAN <шаг> <время_останова> — переходный процесс
*   .AC <тип> <точек> <f_start> <f_stop> — частотный анализ
*   .DC <источник> <начало> <конец> <шаг> — развёртка по DC
*   .OP — рабочая точка
*

.tran 0.1 80m 0 100u

* ------------------------------------------------------------------
* ДИРЕКТИВЫ ВЫВОДА ДАННЫХ
* ------------------------------------------------------------------
*
* Формат: .PRINT <тип_анализа> <переменные>
*
* Переменные:
*   V(<узел>)     — напряжение на узле
*   V(<узел1> <узел2>) — дифференциальное напряжение
*   I(<источник>) — ток через источник
*

.print tran v(out)

* ------------------------------------------------------------------
* КОНЕЦ СХЕМЫ
* ------------------------------------------------------------------
.END
