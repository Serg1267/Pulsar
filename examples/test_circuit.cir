* RC цепь - переходный процесс
* Конденсатор заряжается через резистор

V1 1 0 DC 10
R1 1 2 1k
C1 2 0 1uF IC=0

* Переходный анализ от 0 до 10мс с шагом 0.1мс
.TRAN 0.1ms 10ms

* Вывод напряжения на узле 2
.PRINT TRAN V(2)

.END
