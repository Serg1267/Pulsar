* RC цепь - DC анализ (свипирование напряжения)
* Построение графика V(1) и тока через V1 при изменении напряжения от 0 до 10В
V1 1 0 5
R1 1 2 1k
C1 2 0 1uF
.DC V1 0 10 0.2
.PRINT DC V(1) V(2) I(V1)
.END
