* ====================================================================
* RC-фильтр низких частот
* ====================================================================
*
* Дата создания: 2026-04-10 06:45
* Автор: Pulsar Examples
*
* Описание:
* Простой RC-фильтр низких частот с частотой среза около 1kHz.
* Используется для демонстрации переходного процесса и частотного
* анализа.
*
* ====================================================================

* --------------------------------------------------------------------
* КОМПОНЕНТЫ СХЕМЫ
* --------------------------------------------------------------------
*
* Формат: <имя> <узел+> <узел-> <значение>
*
* Источники напряжения: Vxxx n+ n- <тип> <параметры>
* Резисторы:          Rxxx n+ n- <сопротивление>
* Конденсаторы:       Cxxx n+ n- <ёмкость>
* Индуктивности:      Lxxx n+ n- <индуктивность>
* Диоды:              Dxxx anode cathode <модель>
* Транзисторы:        Qxxx collector base emitter <модель>
*

* --- Источники ---
V1 1 0 SIN(0 1 1k)

* --- Пассивные компоненты ---
R1 1 2 1.5k
C1 2 0 100nF

* --- Полупроводники ---

* --------------------------------------------------------------------
* МОДЕЛИ КОМПОНЕНТОВ
* --------------------------------------------------------------------
*
* Формат: .MODEL <имя> <тип> (<параметры>)
*
* Типы моделей:
*   D   — диод
*   NPN — биполярный NPN-транзистор
*   PNP — биполярный PNP-транзистор
*   NMOS/PMOS — полевые транзисторы
*

* Примеры (закомментируйте или замените своими):
* .MODEL MyDiode D (IS=2.52n RS=.568 N=1.752)
* .MODEL MyTransistor NPN (BF=255.9 VAF=74.03)

* --------------------------------------------------------------------
* ДИРЕКТИВЫ АНАЛИЗА
* --------------------------------------------------------------------
*
* Типы анализов:
*   .TRAN <шаг> <время_останова> — переходный процесс
*   .AC <тип> <точек> <f_start> <f_stop> — частотный анализ
*   .DC <источник> <начало> <конец> <шаг> — развёртка по DC
*   .OP — рабочая точка
*

* --- Переходный анализ ---
* .TRAN <шаг_времени> <время_моделирования>
.TRAN 0.1ms 10ms

* --------------------------------------------------------------------
* ДИРЕКТИВЫ ВЫВОДА ДАННЫХ
* --------------------------------------------------------------------
*
* Формат: .PRINT <тип_анализа> <переменные>
*
* Переменные:
*   V(<узел>)     — напряжение на узле
*   V(<узел1> <узел2>) — дифференциальное напряжение
*   I(<источник>) — ток через источник
*

* --- Вывод напряжений ---
.PRINT TRAN V(2)

* --- Вывод токов ---
* .PRINT TRAN I(V1)

* --------------------------------------------------------------------
* КОНЕЦ СХЕМЫ
* --------------------------------------------------------------------
.END
