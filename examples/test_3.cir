*Test_3

*--------------------
*Синус 12В 50гЦ
V1 1 0 SIN 0 12 50
*--------------------
D1 1 2 D1
C1 2 0 1000uF
R1 2 0 100

.model D1 D rs=50m cjo=10p

.tran 0.1 80m 0 0.0001
.print tran v(2)

.end
