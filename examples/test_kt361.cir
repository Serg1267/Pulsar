* Test KT361B — common-emitter amplifier (PNP)
.title KT361B test
Vee Vee 0 DC -9
Vin Vin 0 SIN(0 0.1 1k)
Rb1 Vee N1 47k
Rb2 N1 0 10k
Rc Vee N2 2k
Re N3 0 1k
Q1 N2 N1 N3 KT361B
*
.include ../Mod/BJT/KT361B.lib
*
.tran 0.05m 10m 0 0.1m
.plot tran v(N2) v(N1) v(Vin)
.end
