ME4856 Transfer Characteristic: ID vs VGS, VDS=10V
M1 D G 0 0 ME4856
VDS D 0 DC 10
VGS G 0

.model ME4856 VDMOS NCHAN ( VTO=1.8 KP=50 LAMBDA=0.01 RD=2.0m RS=1.5m RG=1.0 CGS=2590p CGDMAX=550p CGDMIN=110p A=0.3 CJO=240p VJ=0.8 M=0.5 IS=1e-10 RB=50m BV=30 IBV=250u NBV=4 TT=25n RTHJC=34 )

.dc VGS 0 3 0.01
.plot dc -I(VDS)

.end
