* RC фильтр - AC анализ (частотная характеристика)
* Bode plot: амплитуда и фаза V(2) при sweep частоты 10Гц..1МГц
V1 1 0 AC 1
R1 1 2 1k
C1 2 0 1uF
.AC DEC 10 10 1MEG
.PRINT AC V(2) VP(2)
.END
