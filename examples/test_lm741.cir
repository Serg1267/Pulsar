* LM741 Non-Inverting Amplifier Test
* Gain = 1 + R2/R1 = 11

.SUBCKT LM741 1 2 3 4 5
R741_IN 1 2 2MEG
G741_DIFF 0 10 1 2 0.1
R741_GAIN 10 0 1MEG
C741_POLE 10 0 30P
D741_CLP 10 3 DCLAMP
D741_CLN 4 10 DCLAMP
.MODEL DCLAMP D(IS=1E-15)
E741_OUT 5 0 10 0 1
R741_OUT 5 0 75
.ENDS LM741

RINAMP 2 0 1K
RFB 2 5 10K
X1 1 2 VCC VEE 5 LM741
VIN 1 0 SIN(0 0.5 1k)
VCC VCC 0 DC 15
VEE VEE 0 DC -15

.TRAN 0.1m 5m 0 10u
.PLOT TRAN V(1) V(5)

.END
