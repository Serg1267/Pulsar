* ==================================================================
* RC_timer
* ==================================================================
*
* Дата создания: 2026-06-28 11:24
*
* ==================================================================

* ------------------------------------------------------------------
* КОМПОНЕНТЫ СХЕМЫ
* ------------------------------------------------------------------
*
* Формат: <имя> <узел+> <узел-> <значение>
*
* Источники напряжения: Vxxx n+ n- <тип> <параметры>
* Резисторы:          Rxxx n+ n- <сопротивление>
* Конденсаторы:       Cxxx n+ n- <ёмкость>
* Индуктивности:      Lxxx n+ n- <индуктивность>
* Диоды:              Dxxx anode cathode <модель>
* Транзисторы:        Qxxx collector base emitter <модель>
*

* --- Источники ---
V1 5 0 DC 5
V2 3 0 DC 5
V3 2 0 DC 5

* --- Пассивные компоненты ---
C1 1 0 0.1u
R1 1 5 100k
R2 0 4 1k
R3 out 0 1k

* --- Полупроводники ---
M1 2 4 out 0 ME4856

* --- Другие компоненты ---
S1 3 4 1 0 swmod

* ------------------------------------------------------------------
* МОДЕЛИ КОМПОНЕНТОВ
* ------------------------------------------------------------------
*
* Формат: .MODEL <имя> <тип> (<параметры>)
*
* Типы моделей:
*   D   — диод
*   NPN — биполярный NPN-транзистор
*   PNP — биполярный PNP-транзистор
*   NMOS/PMOS — полевые транзисторы
*

.model ME4856 VDMOS NCHAN ( VTO=1.8 KP=50 LAMBDA=0.01 RD=2.0m RS=1.5m RG=1.0 CGS=2590p CGDMAX=550p CGDMIN=110p A=0.3 CJO=240p VJ=0.8 M=0.5 IS=1e-10 RB=50m BV=30 IBV=250u NBV=4 TT=25n RTHJC=34
.MODEL swmod SW(VT=0.5 VH=0.1 RON=1 ROFF=1G)

* ------------------------------------------------------------------
* ДИРЕКТИВЫ АНАЛИЗА
* ------------------------------------------------------------------
*
* Типы анализов:
*   .TRAN <шаг> <время_останова> — переходный процесс
*   .AC <тип> <точек> <f_start> <f_stop> — частотный анализ
*   .DC <источник> <начало> <конец> <шаг> — развёртка по DC
*   .OP — рабочая точка
*

.tran 1u 2m 0 0.5u uic

* ------------------------------------------------------------------
* ДИРЕКТИВЫ ВЫВОДА ДАННЫХ
* ------------------------------------------------------------------
*
* Формат: .PRINT <тип_анализа> <переменные>
*
* Переменные:
*   V(<узел>)     — напряжение на узле
*   V(<узел1> <узел2>) — дифференциальное напряжение
*   I(<источник>) — ток через источник
*

.plot tran v(out)

* ------------------------------------------------------------------
* КОНЕЦ СХЕМЫ
* ------------------------------------------------------------------
.END
