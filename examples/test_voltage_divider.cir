* Делитель напряжения с источником переменного напряжения
* Источник 24В переменного тока -> R1 -> R2 -> земля

* Синусоидальный источник: 24В амплитуда, 50Гц
V1 1 0 SIN(0 24 50)

* Делитель напряжения
R1 1 2 10k
R2 2 0 10k

* Переходный анализ: 0-40мс с шагом 0.1мс (два периода 50Гц)
.TRAN 0.1ms 80ms

* Вывод напряжений: вход (узел 1) и выход делителя (узел 2)
.PRINT TRAN V(1) V(2)

.END
