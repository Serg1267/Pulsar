* Новая схема SPICE
* Введите вашу схему ниже

V1 1 0 sin(0 12 50)
R1 1 2 2k
R2 2 0 2k

.tran 0.1 40m 0 100u
.PRINT tran v(2)

.END
